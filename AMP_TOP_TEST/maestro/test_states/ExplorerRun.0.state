ADE simulation setup
Test ProjektMZ_AMP_TOP_TEST_1: ProjektMZ/AMP_TOP_TEST/schematic, simulator spectre
  Models: /cad/dk/umc180oa/cds/UMC_18_CMOS/../Models/Spectre/mm180_bjt_v121.lib.scs[tt_bip], /cad/dk/umc180oa/cds/UMC_18_CMOS/../Models/Spectre/mm180_mimcap_v101.lib.scs[mimcaps_typ], /cad/dk/umc180oa/cds/UMC_18_CMOS/../Models/Spectre/mm180_reg18bpw_v123.lib.scs[tt], /cad/dk/umc180oa/cds/UMC_18_CMOS/../Models/Spectre/mm180_reg33bpw_v123.lib.scs[tt], /cad/dk/umc180oa/cds/UMC_18_CMOS/../Models/Spectre/mm180_res_v141.lib.scs[res_typ], /cad/dk/umc180oa/cds/UMC_18_CMOS/../Models/Spectre/mm180_lvt18_v113.lib.scs[tt], /cad/dk/umc180oa/cds/UMC_18_CMOS/../Models/Spectre/mm180_lvt33_v113.lib.scs[tt], /cad/dk/umc180oa/cds/UMC_18_CMOS/../Models/Spectre/mm180_reg18_v124.lib.scs[tt], /cad/dk/umc180oa/cds/UMC_18_CMOS/../Models/Spectre/mm180_reg33_v114.lib.scs[tt], /cad/dk/umc180oa/cds/UMC_18_CMOS/../Models/Spectre/mm180_zvt18_v121.lib.scs[tt], /cad/dk/umc180oa/cds/UMC_18_CMOS/../Models/Spectre/mm180_zvt33_v113.lib.scs[tt], /cad/dk/umc180oa/cds/UMC_18_CMOS/../Models/Spectre/core_rf_v2d4.lib.scs[tt], /cad/dk/umc180oa/cds/UMC_18_CMOS/../Models/Spectre/io_rf_v2d3.lib.scs[tt], /cad/dk/umc180oa/cds/UMC_18_CMOS/../Models/Spectre/l_slcr20k_rf_v2d3.lib.scs[typ], /cad/dk/umc180oa/cds/UMC_18_CMOS/../Models/Spectre/mimcapm_rf_v2d3.lib.scs[typ], /cad/dk/umc180oa/cds/UMC_18_CMOS/../Models/Spectre/pad_rf_v2d3.lib.scs[typ], /cad/dk/umc180oa/cds/UMC_18_CMOS/../Models/Spectre/rnhr_rf_v2d4.lib.scs[typ], /cad/dk/umc180oa/cds/UMC_18_CMOS/../Models/Spectre/rnnpo_rf_v2d4.lib.scs[typ], /cad/dk/umc180oa/cds/UMC_18_CMOS/../Models/Spectre/rnppo_rf_v2d4.lib.scs[typ], /cad/dk/umc180oa/cds/UMC_18_CMOS/../Models/Spectre/vardiop_rf_v2d3.lib.scs[typ], /cad/dk/umc180oa/cds/UMC_18_CMOS/../Models/Spectre/varmis_18_rf_v2d3.lib.scs[typ], /cad/dk/umc180oa/cds/UMC_18_CMOS/../Models/Spectre/mm180_diode_v113.mdl.scs
  Variables: vin_cm = 900m; CM = 0.1p; dac_bit = 0; IREF_CONST = 1u; IREF_DAC = 100n; m_M4 = 4; m_M4A = 1; m_M6 = 10; m_M6A = 1; R_STAB = 8k; VDD = 1.8
  Temperature: 27
  Analysis stb: start=1 stop=1G dec=50 probe=/IPRB1 stbProbeMode=differential
  Output Loop Gain Phase = phaseDegUnwrapped(getData("loopGain" ?result "stb"))
  Output Loop Gain dB20 = db(mag(getData("loopGain" ?result "stb")))
  Signals: /OUT
