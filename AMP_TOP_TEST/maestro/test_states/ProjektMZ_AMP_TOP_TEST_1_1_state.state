ADE simulation setup
Test ProjektMZ_AMP_TOP_TEST_1_1: ProjektMZ/AMP_TOP_TEST/schematic, simulator spectre
  Models: /cad/dk/umc180oa/cds/UMC_18_CMOS/../Models/Spectre/mm180_bjt_v121.lib.scs[tt_bip], /cad/dk/umc180oa/cds/UMC_18_CMOS/../Models/Spectre/mm180_mimcap_v101.lib.scs[mimcaps_typ], /cad/dk/umc180oa/cds/UMC_18_CMOS/../Models/Spectre/mm180_reg18bpw_v123.lib.scs[tt], /cad/dk/umc180oa/cds/UMC_18_CMOS/../Models/Spectre/mm180_reg33bpw_v123.lib.scs[tt], /cad/dk/umc180oa/cds/UMC_18_CMOS/../Models/Spectre/mm180_res_v141.lib.scs[res_typ], /cad/dk/umc180oa/cds/UMC_18_CMOS/../Models/Spectre/mm180_lvt18_v113.lib.scs[tt], /cad/dk/umc180oa/cds/UMC_18_CMOS/../Models/Spectre/mm180_lvt33_v113.lib.scs[tt], /cad/dk/umc180oa/cds/UMC_18_CMOS/../Models/Spectre/mm180_reg18_v124.lib.scs[tt], /cad/dk/umc180oa/cds/UMC_18_CMOS/../Models/Spectre/mm180_reg33_v114.lib.scs[tt], /cad/dk/umc180oa/cds/UMC_18_CMOS/../Models/Spectre/mm180_zvt18_v121.lib.scs[tt], /cad/dk/umc180oa/cds/UMC_18_CMOS/../Models/Spectre/mm180_zvt33_v113.lib.scs[tt], /cad/dk/umc180oa/cds/UMC_18_CMOS/../Models/Spectre/core_rf_v2d4.lib.scs[tt], /cad/dk/umc180oa/cds/UMC_18_CMOS/../Models/Spectre/io_rf_v2d3.lib.scs[tt], /cad/dk/umc180oa/cds/UMC_18_CMOS/../Models/Spectre/l_slcr20k_rf_v2d3.lib.scs[typ], /cad/dk/umc180oa/cds/UMC_18_CMOS/../Models/Spectre/mimcapm_rf_v2d3.lib.scs[typ], /cad/dk/umc180oa/cds/UMC_18_CMOS/../Models/Spectre/pad_rf_v2d3.lib.scs[typ], /cad/dk/umc180oa/cds/UMC_18_CMOS/../Models/Spectre/rnhr_rf_v2d4.lib.scs[typ], /cad/dk/umc180oa/cds/UMC_18_CMOS/../Models/Spectre/rnnpo_rf_v2d4.lib.scs[typ], /cad/dk/umc180oa/cds/UMC_18_CMOS/../Models/Spectre/rnppo_rf_v2d4.lib.scs[typ], /cad/dk/umc180oa/cds/UMC_18_CMOS/../Models/Spectre/vardiop_rf_v2d3.lib.scs[typ], /cad/dk/umc180oa/cds/UMC_18_CMOS/../Models/Spectre/varmis_18_rf_v2d3.lib.scs[typ], /cad/dk/umc180oa/cds/UMC_18_CMOS/../Models/Spectre/mm180_diode_v113.mdl.scs
  Variables: AMPL_IN = 20m; vin_cm = 900m; CM = 0.85p; dac_bit = 31; IREF_CONST = 3.5u; IREF_DAC = 200n; m_M4 = 2; m_M4A = 4; m_M6 = 8; m_M6A = 6; R_STAB = 5k; VDD = 1.8
  Temperature: 27
  Analysis ac: start=0.5M stop=1G dec=100
  Analysis stb: start=1 stop=1G dec=50 probe=/IPRB1 stbProbeMode=differential
  Output phaseDeg(VF("/OUT")) (unticked)
  Output dB20(VF("/OUT")) (unticked)
  Output Phase Margin = getData("phaseMargin" ?result "stb_margin")
  Output Gain Margin = getData("gainMargin" ?result "stb_margin") (unticked)
  Output bandwidth(VF("/OUT") 3 "low")
  Output IDC("/I0/M4/D") (unticked)
  Output Moc Diff = ((IDC("/I0/M4/D") + IDC("/I0/M4A/D")) * 1.8 * -1) (unticked)
  Output Moc CS = ((IDC("/I0/M6/D") + IDC("/I0/M6A/D")) * 1.8 * -1) (unticked)
  Output Moc Stopnia Sterowania = ((IDC("/I0/M7/D") + IDC("/I0/M8/D")) * 1.8) (unticked)
  Signals: /I0/M4/D (terminal), /I0/M4A/D (terminal), /I0/M6/D (terminal), /I0/M6A/D (terminal), /I0/M7/D (terminal), /I0/M8/D (terminal)
