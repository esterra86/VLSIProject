ADE simulation setup
Test ProjektMZ_AMP_TOP_TEST_2: ProjektMZ/AMP_TOP_TEST/config, simulator spectre
  Models: /cad/dk/umc180oa/cds/UMC_18_CMOS/../Models/Spectre/mm180_bjt_v121.lib.scs[tt_bip], /cad/dk/umc180oa/cds/UMC_18_CMOS/../Models/Spectre/mm180_mimcap_v101.lib.scs[mimcaps_typ], /cad/dk/umc180oa/cds/UMC_18_CMOS/../Models/Spectre/mm180_reg18bpw_v123.lib.scs[tt], /cad/dk/umc180oa/cds/UMC_18_CMOS/../Models/Spectre/mm180_reg33bpw_v123.lib.scs[tt], /cad/dk/umc180oa/cds/UMC_18_CMOS/../Models/Spectre/mm180_res_v141.lib.scs[res_typ], /cad/dk/umc180oa/cds/UMC_18_CMOS/../Models/Spectre/mm180_lvt18_v113.lib.scs[tt], /cad/dk/umc180oa/cds/UMC_18_CMOS/../Models/Spectre/mm180_lvt33_v113.lib.scs[tt], /cad/dk/umc180oa/cds/UMC_18_CMOS/../Models/Spectre/mm180_reg18_v124.lib.scs[tt], /cad/dk/umc180oa/cds/UMC_18_CMOS/../Models/Spectre/mm180_reg33_v114.lib.scs[tt], /cad/dk/umc180oa/cds/UMC_18_CMOS/../Models/Spectre/mm180_zvt18_v121.lib.scs[tt], /cad/dk/umc180oa/cds/UMC_18_CMOS/../Models/Spectre/mm180_zvt33_v113.lib.scs[tt], /cad/dk/umc180oa/cds/UMC_18_CMOS/../Models/Spectre/core_rf_v2d4.lib.scs[tt], /cad/dk/umc180oa/cds/UMC_18_CMOS/../Models/Spectre/io_rf_v2d3.lib.scs[tt], /cad/dk/umc180oa/cds/UMC_18_CMOS/../Models/Spectre/l_slcr20k_rf_v2d3.lib.scs[typ], /cad/dk/umc180oa/cds/UMC_18_CMOS/../Models/Spectre/mimcapm_rf_v2d3.lib.scs[typ], /cad/dk/umc180oa/cds/UMC_18_CMOS/../Models/Spectre/pad_rf_v2d3.lib.scs[typ], /cad/dk/umc180oa/cds/UMC_18_CMOS/../Models/Spectre/rnhr_rf_v2d4.lib.scs[typ], /cad/dk/umc180oa/cds/UMC_18_CMOS/../Models/Spectre/rnnpo_rf_v2d4.lib.scs[typ], /cad/dk/umc180oa/cds/UMC_18_CMOS/../Models/Spectre/rnppo_rf_v2d4.lib.scs[typ], /cad/dk/umc180oa/cds/UMC_18_CMOS/../Models/Spectre/vardiop_rf_v2d3.lib.scs[typ], /cad/dk/umc180oa/cds/UMC_18_CMOS/../Models/Spectre/varmis_18_rf_v2d3.lib.scs[typ], /cad/dk/umc180oa/cds/UMC_18_CMOS/../Models/Spectre/mm180_diode_v113.mdl.scs
  Variables: FREQ_IN = 1M; VIN = 0; AMPL_IN = 20m; dac_bit = 0.0; VDD = 1.8; vin_cm = 0.9
  Temperature: 27
  Analysis tran: stop=2u errpreset=moderate
  Output phaseDeg(VF("/OUT")) (unticked)
  Output dB20(VF("/OUT")) (unticked)
  Output Phase Margin = getData("phaseMargin" ?result "stb_margin") (unticked)
  Output Gain Margin = getData("gainMargin" ?result "stb_margin") (unticked)
  Output bandwidth(VF("/OUT") 3 "low") (unticked)
  Output IDC("/I0/M4/D") (unticked)
  Output Moc Diff = ((IDC("/I0/M4/D") + IDC("/I0/M4A/D")) * 1.8 * -1) (unticked)
  Output Moc CS = ((IDC("/I0/M6/D") + IDC("/I0/M6A/D")) * 1.8 * -1) (unticked)
  Output Moc Stopnia Sterowania = ((IDC("/I0/M7/D") + IDC("/I0/M8/D")) * 1.8) (unticked)
  Output rmsNoise(0.001 1000000) (unticked)
  Output input noise; V**2 / Hz = (getData("in" ?result "noise")**2) (unticked)
  Output rms((getData("in" ?result "noise")**2)) (unticked)
  Output output noise; V**2 / Hz = (getData("out" ?result "noise")**2) (unticked)
  Output rms((getData("out" ?result "noise")**2)) (unticked)
  Output rms output referred noise = sqrt(integ((getData("out" ?result "noise")**2) 0.001 1000000)) (unticked)
  Output rms input referred noise = sqrt(integ((getData("in" ?result "noise")**2) 0.001 1000000)) (unticked)
  Output sqrt(integ((VNIN()**2) 0.001 1000000)) (unticked)
  Signals: /OUT
Run mode: Single Run, Sweeps and Corners
Global variables:
  CONFIG/ProjektMZ/AMP_TOP = schematic av_extracted
Setup values for test ProjektMZ_AMP_TOP_TEST_2: dac_bit = 0 16 31
Disabled tests: ProjektMZ_AMP_TOP_TEST_1
