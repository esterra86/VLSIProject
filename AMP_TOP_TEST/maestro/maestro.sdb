ADE simulation setup
Run mode: Single Run, Sweeps and Corners
Tests:
  ProjektMZ_AMP_TOP_TEST_2: ProjektMZ/AMP_TOP_TEST/config, simulator spectre
    Variables: dac_bit = 0 16 31; AMPL_IN = 20m; VDD = 1.8; vin_cm = 0.9; VIN = 0; FREQ_IN = 1M
    Outputs: /I0/net6; /OUT; Moc Diff; Moc CS; Moc Stopnia Sterowania; rms((getData("in" ?result "noise")**2)); rms((getData("out" ?result "noise")**2)); rms output referred noise; rms input referred noise; sqrt(integ((VNIN()**2) 0.001 1000000))
Global variables:
  CONFIG/ProjektMZ/AMP_TOP = schematic av_extracted
